// Copyright (c) 2021 Arm Ltd.
// All rights reserved.
//
// SPDX-License-Identifier: BSD-3-Clause
//
// Engineer: fernando.garciaredondo@arm.com
//           pranay.prabhat@arm.com
//
// Arm physical constants

`ifndef _physical_constants_
`define _physical_constants_

`include "disciplines.vams"
`include "constants.vams"

// // CONSTANTS
// // gyromagnetic ratio
// // https://www.ctcms.nist.gov/~rdm/mumag.org.html
// // equivalent to c_U0*2.211e5 (ommited often [rad]) * [m/C] = ([rad]) * [ m/A/s]
// `define c_GAMMA_0 1.76e11             // [rad/s/T]
//
// // elementary charge, [C]
// `define c_E `P_Q	              // 1.602176462e-19
// // reduced plank's constant [J s]
// `define c_HBAR (`P_H/(2*`M_PI))         // 6.6260755e-34 / 2*PI
// // vacuum permeability, 4 pi / 1e7 [H/m]
// `define c_U0 (4*`M_PI/1e7)            // 1.25663706212e-6
// // boltzmann's constant [J/K]
// `define c_KB 1.3806503e-23
// // Borh magneton [J/T]
// `define c_UB (c_GAMMA_0 * c_HBAR / 2)

// gyromagnetic ratio
// https://www.ctcms.nist.gov/~rdm/mumag.org.html
// equivalent to c_U0*2.211e5 (ommited often [rad]) * [m/C] = ([rad]) * [ m/A/s]
parameter real c_GAMMA_0 = 1.76e11;             // [rad/s/T]
// elementary charge, [C]
parameter real c_E = `P_Q;	              // 1.602176462e-19
// reduced plank's constant [J s]
parameter real c_HBAR = `P_H/(2*`M_PI);        // 6.6260755e-34 / 2*PI
// vacuum permeability, 4 pi / 1e7 [H/m]
parameter real c_U0 = 4*`M_PI/1e7;            // 1.25663706212e-6
// boltzmann's constant [J/K]
parameter real c_KB = 1.3806503e-23;
// Borh magneton [J/T]
parameter real c_UB = c_GAMMA_0 * c_HBAR / 2;

`endif
